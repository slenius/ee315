// Design: ee315/example_cs
simulator lang=spectre
global 0 vdd!
include "/afs/ir.stanford.edu/class/ee315/models/ee315.mod"

// ee315/example_cs/schematic
VDD (vdd! 0) vsource dc=1.8 type=dc
RL (vdd! out) resistor r=2K
VIN (in 0) vsource dc=700.0m mag=1 phase=0 type=sine sinedc=0 ampl=1 sinephase=0 freq=1K fundname="fund"
CL (out 0) capacitor c=1p
M1 (out in 0 0) nmos w=10u l=0.18u
simulatorOptions options temp=27
ac ac start=10e3 stop=1e9
dcOp dc
dc dc dev=VIN param=dc start=0 stop=1.8
