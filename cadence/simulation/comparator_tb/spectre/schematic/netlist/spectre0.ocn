simulator( 'spectre )
design(	 "/home/lenius/ee315/cadence/simulation/comparator_tb/spectre/schematic/netlist/netlist")
resultsDir( "/home/lenius/ee315/cadence/simulation/comparator_tb/spectre/schematic" )
modelFile(
    '("/afs/ir.stanford.edu/class/ee315/models/ee315.mod" "")
)
analysis('tran ?stop "15n"  ?errpreset "conservative"  )
desVar(	  "vid" 1m	)
desVar(	  "vic" 0.9	)
desVar(	  "vdd" 1.8	)
envOption(
	'analysisOrder  list("tran")
)
temp( 27 )
run()
modelFile(
    '("/afs/ir.stanford.edu/class/ee315/models/ee315.mod" "")
)
run()
modelFile(
    '("/afs/ir.stanford.edu/class/ee315/models/ee315.mod" "")
)
run()
modelFile(
    '("/afs/ir.stanford.edu/class/ee315/models/ee315.mod" "")
)
run()
selectResult( 'tran )
plot(getData("/vod") getData("/vom") getData("/vop") getData("/str") )
modelFile(
    '("/afs/ir.stanford.edu/class/ee315/models/ee315.mod" "")
)
run()
selectResult( 'tran )
plot(getData("/vod") getData("/vom") getData("/vop") getData("/str") )
modelFile(
    '("/afs/ir.stanford.edu/class/ee315/models/ee315.mod" "")
)
desVar(	  "vid" 100u	)
run()
selectResult( 'tran )
plot(getData("/vod") getData("/vom") getData("/vop") getData("/str") )
modelFile(
    '("/afs/ir.stanford.edu/class/ee315/models/ee315.mod" "")
)
run()
selectResult( 'tran )
plot(getData("/vod") getData("/vom") getData("/vop") getData("/str") )
modelFile(
    '("/afs/ir.stanford.edu/class/ee315/models/ee315.mod" "")
)
desVar(	  "vid" 1u	)
run()
selectResult( 'tran )
plot(getData("/vod") getData("/vom") getData("/vop") getData("/str") )
modelFile(
    '("/afs/ir.stanford.edu/class/ee315/models/ee315.mod" "")
)
desVar(	  "vid" 1p	)
run()
selectResult( 'tran )
plot(getData("/vod") getData("/vom") getData("/vop") getData("/str") )
modelFile(
    '("/afs/ir.stanford.edu/class/ee315/models/ee315.mod" "")
)
desVar(	  "vid" 100u	)
run()
selectResult( 'tran )
plot(getData("/vod") getData("/vom") getData("/vop") getData("/str") )
modelFile(
    '("/afs/ir.stanford.edu/class/ee315/models/ee315.mod" "")
)
desVar(	  "vid" 100m	)
run()
selectResult( 'tran )
plot(getData("/vod") getData("/vom") getData("/vop") getData("/str") )
modelFile(
    '("/afs/ir.stanford.edu/class/ee315/models/ee315.mod" "")
)
run()
selectResult( 'tran )
plot(getData("/vod") )
modelFile(
    '("/afs/ir.stanford.edu/class/ee315/models/ee315.mod" "")
)
analysis('dc ?saveOppoint t  )
envOption(
	'analysisOrder  list("tran" "dc")
)
run()
selectResult( 'tran )
plot(getData("/vod") )
selectResult( 'dcOp )
plot(getData("/vod") )
modelFile(
    '("/afs/ir.stanford.edu/class/ee315/models/ee315.mod" "")
)
run()
selectResult( 'tran )
plot(getData("/vod") )
selectResult( 'dcOp )
plot(getData("/vod") )
modelFile(
    '("/afs/ir.stanford.edu/class/ee315/models/ee315.mod" "")
)
analysis('dc ?captab t  )
run()
selectResult( 'tran )
plot(getData("/vod") )
selectResult( 'dcOp )
plot(getData("/vod") )
modelFile(
    '("/afs/ir.stanford.edu/class/ee315/models/ee315.mod" "")
)
desVar(	  "vid" 1u	)
run()
selectResult( 'tran )
plot(getData("/vod") )
selectResult( 'dcOp )
plot(getData("/vod") )
