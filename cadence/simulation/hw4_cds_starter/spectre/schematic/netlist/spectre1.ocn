simulator( 'spectre )
design(	 "/home/lenius/ee315/cadence/simulation/hw4_cds_starter/spectre/schematic/netlist/netlist")
resultsDir( "/home/lenius/ee315/cadence/simulation/hw4_cds_starter/spectre/schematic" )
modelFile(
    '("/afs/ir.stanford.edu/class/ee315a/models/ee315a.mod" "")
)
analysis('noise ?start "1e3"  ?stop "1e12"  ?p "qx"
		?n "gnd!"  ?oprobe ""  ?iprobe "/V1"  )
analysis('dc ?saveOppoint t  )
desVar(	  "ronf" "1/2/fs/M/cf"	)
desVar(	  "rons" "1/2/fs/M/cs"	)
desVar(	  "init_v" "(t0_phase-1)*vdd"	)
desVar(	  "cl" 2p	)
desVar(	  "t0_phase" 1	)
desVar(	  "M" 100	)
desVar(	  "swnoise" 1	)
desVar(	  "cs" 2p	)
desVar(	  "cf" 1p	)
desVar(	  "tfall" 100p	)
desVar(	  "tnov" 200p	)
desVar(	  "trise" 100p	)
desVar(	  "p1_duty" 0.5	)
desVar(	  "fs" 10M	)
desVar(	  "vdd" 1.8	)
envOption(
	'analysisOrder  list("dc" "noise")
)
temp( 27 )
run()
ac\ noise\ integral = sqrt(iinteg((getData("/out" ?result "noise-noise")**2)))
plot( ac\ noise\ integral ?expr '( "ac noise integral" ) )
modelFile(
    '("/afs/ir.stanford.edu/class/ee315a/models/ee315a.mod" "")
)
desVar(	  "swnoise" 0	)
run()
ac\ noise\ integral = sqrt(iinteg((getData("/out" ?result "noise-noise")**2)))
plot( ac\ noise\ integral ?expr '( "ac noise integral" ) )
modelFile(
    '("/afs/ir.stanford.edu/class/ee315a/models/ee315a.mod" "")
)
analysis('noise ?p "/vo"  )
desVar(	  "t0_phase" 2	)
desVar(	  "swnoise" 1	)
run()
ac\ noise\ integral = sqrt(iinteg((getData("/out" ?result "noise-noise")**2)))
plot( ac\ noise\ integral ?expr '( "ac noise integral" ) )
