// Design: hw4/hw4_cds_flicker
simulator lang=spectre
global 0 p2! p1!
parameters cds_en=0 flicker_on=0 vos=0 vdd=1.8 fs=10M p1_duty=0.5 trise=100p tnov=200p tfall=100p cf=1p cs=2p swnoise=1 M=100 t0_phase=1 cl=2p init_v=(t0_phase-1)*vdd rons=1/2/fs/M/cs ronf=1/2/fs/M/cf
include "/afs/ir.stanford.edu/class/ee315a/models/ee315a.mod"

// ee315/clock_gen_e/schematic
subckt clock_gen_e p1 p1b p1e p1eb p2 p2b p2e vdd
    F9 (vdd 0) cccs gain=-0.5 abs=on probe=E4
    F8 (vdd 0) cccs gain=0.5 probe=E4
    F7 (vdd 0) cccs gain=-0.5 abs=on probe=E3
    F5 (vdd 0) cccs gain=0.5 probe=E3
    F4 (vdd 0) cccs gain=-0.5 abs=on probe=E1
    F3 (vdd 0) cccs gain=0.5 probe=E1
    F2 (vdd 0) cccs gain=-0.5 abs=on probe=E2
    F1 (vdd 0) cccs gain=0.5 probe=E2
    F0 (vdd 0) cccs gain=-0.5 abs=on probe=E0
    G0 (vdd 0) cccs gain=0.5 probe=E0
    R6 (net083 net027) resistor r=50 isnoisy=no
    R5 (net085 net029) resistor r=50 isnoisy=no
    R4 (net060 net072) resistor r=50 isnoisy=no
    R3 (net050 net018) resistor r=50 isnoisy=no
    R2 (net036 net012) resistor r=50 isnoisy=no
    R1 (net09 net013) resistor r=50 isnoisy=no
    R0 (net7 net9) resistor r=50 isnoisy=no
    V6 (net083 0) vsource type=pulse val0=vdd-init_v val1=init_v period=1/fs delay=(1-p1_duty)/fs-trise-2*tnov rise=tfall fall=trise width=(1-p1_duty)/fs-trise+2*tnov
    V5 (net085 0) vsource type=pulse val0=vdd-init_v val1=init_v period=1/fs delay=(1-p1_duty)/fs-trise-tnov rise=tfall fall=trise width=(1-p1_duty)/fs-trise+tnov
    V3 (net060 0) vsource type=pulse val0=vdd-init_v val1=init_v period=1/fs delay=(1-p1_duty)/fs-trise rise=trise fall=tfall width=(1-p1_duty)/fs-trise-tnov
    V4 (net050 0) vsource type=pulse val0=init_v val1=vdd-init_v period=1/fs delay=(1-p1_duty)/fs- trise rise=trise fall=tfall width=(1-p1_duty)/fs-trise-2*tnov
    V0 (net036 0) vsource type=pulse val0=init_v val1=vdd-init_v period=1/fs delay=(1-p1_duty)/fs-trise-2*tnov rise=tfall fall=trise width=(1-p1_duty)/fs-trise+2*tnov
    Vp2 (net09 0) vsource type=pulse val0=init_v val1=vdd-init_v period=1/fs delay=(1-p1_duty)/fs- trise rise=trise fall=tfall width=(1-p1_duty)/fs-trise-tnov
    Vp1 (net7 0) vsource type=pulse val0=init_v val1=vdd-init_v period=1/fs delay=(1-p1_duty)/fs-trise-tnov rise=tfall fall=trise width=(1-p1_duty)/fs-trise+tnov
    C6 (net027 0) capacitor c=1p
    C5 (net029 0) capacitor c=1p
    C4 (net072 0) capacitor c=1p
    C3 (net018 0) capacitor c=1p
    C2 (net012 0) capacitor c=1p
    C1 (net013 0) capacitor c=1p
    C0 (net9 0) capacitor c=1p
    E6 (p1e 0 net027 0) vcvs gain=1.0
    E5 (p1 0 net029 0) vcvs gain=1.0
    E4 (p2b 0 net072 0) vcvs gain=1.0
    E3 (p2e 0 net018 0) vcvs gain=1.0
    E2 (p1eb 0 net012 0) vcvs gain=1.0
    E1 (p2 0 net013 0) vcvs gain=1.0
    E0 (p1b 0 net9 0) vcvs gain=1.0
ends clock_gen_e

// ee315/OTA1_diff_in/schematic
subckt OTA1_diff_in vin vout vip
parameters Gm ft a0 alpha
    C0 (vin vip) capacitor c=abs(Gm/(2*3.14159*ft))
    F0 (vout 0) cccs gain=1.0 probe=V0
    G0 (vout 0 vin vip) vccs gm=Gm
    V0 (net12 0) vsource dc=0 type=dc
    R1 (vout 0) resistor r=abs(a0/Gm) isnoisy=no
    R0 (net12 0) resistor r=abs(1/(alpha*Gm)) isnoisy=yes
ends OTA1_diff_in

// ee315/p1_switch/schematic
subckt p1_switch s1 s2
parameters Ron=1 SwitchNoise=1
    p1switch (s1 net014 p1! 0) relay vt1=400m vt2=800m ropen=100G rclosed=1
    R5 (net07 0) resistor r=Ron isnoisy=yes
    R4 (net014 s2) resistor r=Ron isnoisy=no
    F0 (net014 s2) cccs gain=SwitchNoise probe=V0
    V0 (net07 0) vsource type=dc
    C1 (net014 0) capacitor c=100.0a
    C0 (s1 0) capacitor c=100.0a
ends p1_switch

// ee315/p2_switch/schematic
subckt p2_switch s1 s2
parameters Ron=1 SwitchNoise=1
    p1switch (s1 net014 p2! 0) relay vt1=400m vt2=800m ropen=100G rclosed=1
    R5 (net07 0) resistor r=Ron isnoisy=yes
    R4 (net014 s2) resistor r=Ron isnoisy=no
    F0 (net014 s2) cccs gain=SwitchNoise probe=V0
    V0 (net07 0) vsource type=dc
    C1 (net014 0) capacitor c=100.0a
    C0 (s1 0) capacitor c=100.0a
ends p2_switch

// ee315/switch_ideal/schematic
subckt switch_ideal clk s1 s2
parameters Ron=10
    C1 (net9 0) capacitor c=100.0a
    C0 (s1 0) capacitor c=100.0a
    R2 (net9 s2) resistor r=Ron isnoisy=yes
    R1 (net9 0) resistor r=100G isnoisy=no
    R0 (s1 0) resistor r=100G isnoisy=no
    p1switch (s1 net9 clk 0) relay vt1=400m vt2=800m ropen=100G rclosed=1m
ends switch_ideal

// ee315/flicker_src/schematic
subckt flicker_src pin1 pin2 inh_bulk_n
    E0 (pin2 pin1 r 0) vcvs gain=0.5*flicker_on
    M0 (r r 0 inh_bulk_n) nmos w=10u l=0.18u
    I4 (0 r) isource dc=1m type=dc
ends flicker_src

// hw4/hw4_cds_flicker/schematic
I31 (p1! net020 net018 net026 p2! net016 net017 net08) clock_gen_e
C3 (vo 0) capacitor c=cl
Cs (vx vs) capacitor c=cs
Cf (vx vy) capacitor c=cf
E2 (qx net019 vx vs) vcvs gain=cs
E0 (net019 0 vx vy) vcvs gain=cf
I1 (vx net014 net015) OTA1_diff_in Gm=1m ft=1e15 a0=1e9 alpha=3
I40 (net028 vs) p1_switch Ron=rons SwitchNoise=swnoise
I20 (vy net031) p1_switch Ron=ronf SwitchNoise=swnoise
I18 (vx net014) p1_switch Ron=ronf SwitchNoise=swnoise
V4 (cds_en_b 0) vsource dc=vdd*(1-cds_en) type=dc
V3 (cds_en 0) vsource dc=vdd*cds_en type=dc
V2 (net011 0) vsource dc=vos pacmag=1 type=dc
V1 (vi 0) vsource dc=2m type=dc
V0 (net08 0) vsource dc=vdd type=dc
I28 (net014 vo) p2_switch Ron=ronf SwitchNoise=swnoise
I11 (vi vs) p2_switch Ron=rons SwitchNoise=swnoise
I19 (vy net014) p2_switch Ron=ronf SwitchNoise=swnoise
I53 (cds_en_b net028 vx) switch_ideal Ron=1m
I51 (cds_en 0 net028) switch_ideal Ron=1m
I49 (cds_en net031 0) switch_ideal Ron=1m
I48 (cds_en_b vx net031) switch_ideal Ron=1m
I46 (net011 net015 0) flicker_src
simulatorOptions options temp=27
pss pss fund=10M harms=0 errpreset=conservative maxacfreq=2G
+ annotate=status
pnoise ( vo 0 ) pnoise start=1 stop=5M maxsideband=200
+ noisetype=timedomain numberofpoints=0 noisetimepoints=[80p]
+ annotate=status
