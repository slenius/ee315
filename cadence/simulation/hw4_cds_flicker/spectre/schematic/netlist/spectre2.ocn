simulator( 'spectre )
design(	 "/home/lenius/ee315/cadence/simulation/hw4_cds_flicker/spectre/schematic/netlist/netlist")
resultsDir( "/home/lenius/ee315/cadence/simulation/hw4_cds_flicker/spectre/schematic" )
modelFile(
    '("/afs/ir.stanford.edu/class/ee315a/models/ee315a.mod" "")
)
analysis('pnoise ?start "1"  ?stop "5M"  ?maxsideband "200"
		?p "/vo"  ?n "/gnd!"  ?oprobe ""  ?iprobe ""
		?refsideband ""  ?noisetype "timedomain"  ?numberofpoints "0"  ?noisetimepoints list("80p")  )
analysis('pss ?fund "10M"  ?harms "0"  ?errpreset "conservative"
		?maxacfreq "2G"  )
desVar(	  "ronf" "1/2/fs/M/cf"	)
desVar(	  "rons" "1/2/fs/M/cs"	)
desVar(	  "init_v" "(t0_phase-1)*vdd"	)
desVar(	  "cl" 2p	)
desVar(	  "t0_phase" 1	)
desVar(	  "M" 100	)
desVar(	  "swnoise" 1	)
desVar(	  "cs" 2p	)
desVar(	  "cf" 1p	)
desVar(	  "tfall" 100p	)
desVar(	  "tnov" 200p	)
desVar(	  "trise" 100p	)
desVar(	  "p1_duty" 0.5	)
desVar(	  "fs" 10M	)
desVar(	  "vdd" 1.8	)
desVar(	  "vos" 0	)
desVar(	  "flicker_on" 0	)
desVar(	  "cds_en" 1	)
envOption(
	'analysisOrder  list("pss" "pnoise")
)
temp( 27 )
run()
Total\ integrated\ noise\ \(RMS\) = average(pow(integ(pow(clip(getData("out" ?result "pnoise_td") 1 5000000) 2)) 0.5))
plot( Total\ integrated\ noise\ \(RMS\) ?expr '( "Total integrated noise (RMS)" ) )
Noise\ PSD\ \(V\/Hz\) = db10(getData("out" ?result "pnoise_td"))
plot( Noise\ PSD\ \(V\/Hz\) ?expr '( "Noise PSD (V/Hz)" ) )
modelFile(
    '("/afs/ir.stanford.edu/class/ee315a/models/ee315a.mod" "")
)
run()
Total\ integrated\ noise\ \(RMS\) = average(pow(integ(pow(clip(getData("out" ?result "pnoise_td") 1 5000000) 2)) 0.5))
plot( Total\ integrated\ noise\ \(RMS\) ?expr '( "Total integrated noise (RMS)" ) )
Noise\ PSD\ \(V\/Hz\) = db10(getData("out" ?result "pnoise_td"))
plot( Noise\ PSD\ \(V\/Hz\) ?expr '( "Noise PSD (V/Hz)" ) )
modelFile(
    '("/afs/ir.stanford.edu/class/ee315a/models/ee315a.mod" "")
)
desVar(	  "flicker_on" 1	)
run()
Total\ integrated\ noise\ \(RMS\) = average(pow(integ(pow(clip(getData("out" ?result "pnoise_td") 1 5000000) 2)) 0.5))
plot( Total\ integrated\ noise\ \(RMS\) ?expr '( "Total integrated noise (RMS)" ) )
modelFile(
    '("/afs/ir.stanford.edu/class/ee315a/models/ee315a.mod" "")
)
desVar(	  "cds_en" 0	)
run()
Total\ integrated\ noise\ \(RMS\) = average(pow(integ(pow(clip(getData("out" ?result "pnoise_td") 1 5000000) 2)) 0.5))
plot( Total\ integrated\ noise\ \(RMS\) ?expr '( "Total integrated noise (RMS)" ) )
Noise\ PSD\ \(V\/Hz\) = db10(getData("out" ?result "pnoise_td"))
plot( Noise\ PSD\ \(V\/Hz\) ?expr '( "Noise PSD (V/Hz)" ) )
modelFile(
    '("/afs/ir.stanford.edu/class/ee315a/models/ee315a.mod" "")
)
desVar(	  "cds_en" 1	)
run()
Total\ integrated\ noise\ \(RMS\) = average(pow(integ(pow(clip(getData("out" ?result "pnoise_td") 1 5000000) 2)) 0.5))
plot( Total\ integrated\ noise\ \(RMS\) ?expr '( "Total integrated noise (RMS)" ) )
Noise\ PSD\ \(V\/Hz\) = db10(getData("out" ?result "pnoise_td"))
plot( Noise\ PSD\ \(V\/Hz\) ?expr '( "Noise PSD (V/Hz)" ) )
modelFile(
    '("/afs/ir.stanford.edu/class/ee315a/models/ee315a.mod" "")
)
desVar(	  "flicker_on" 0	)
desVar(	  "cds_en" 0	)
run()
Total\ integrated\ noise\ \(RMS\) = average(pow(integ(pow(clip(getData("out" ?result "pnoise_td") 1 5000000) 2)) 0.5))
plot( Total\ integrated\ noise\ \(RMS\) ?expr '( "Total integrated noise (RMS)" ) )
Noise\ PSD\ \(V\/Hz\) = db10(getData("out" ?result "pnoise_td"))
plot( Noise\ PSD\ \(V\/Hz\) ?expr '( "Noise PSD (V/Hz)" ) )
