simulator( 'spectre )
design(	 "/afs/.ir.stanford.edu/users/l/e/lenius/ee315/cadence/simulation/p3/spectre/schematic/netlist/netlist")
resultsDir( "/afs/.ir.stanford.edu/users/l/e/lenius/ee315/cadence/simulation/p3/spectre/schematic" )
modelFile(
    '("/afs/ir.stanford.edu/class/ee315/models/ee315.mod" "")
)
analysis('dc ?param "vin"  ?start "0"  ?stop "1.8"  )
desVar(	  "vin" 0	)
envOption(
	'analysisOrder  list("dc")
)
save( 'i "/M0/D" "/M0/S" "/M0/G" "/M2/S" "/M2/G" "/M2/B" "/M2/D" )
temp( 27 )
run()
modelFile(
    '("/afs/ir.stanford.edu/class/ee315/models/ee315.mod" "")
)
run()
selectResult( 'dc )
plot(getData("/in") getData("/out") )
modelFile(
    '("/afs/ir.stanford.edu/class/ee315/models/ee315.mod" "")
)
analysis('dc ?saveOppoint t  )
save( 'v "/in" "/out" )
save( 'i /M0/D /M0/S /M0/G /M2/S /M2/G /M2/B /M2/D )
run()
selectResult( 'dc )
plot(getData("/in") getData("/out") )
modelFile(
    '("/afs/ir.stanford.edu/class/ee315/models/ee315.mod" "")
)
analysis('dc ?save "all"  )
run()
selectResult( 'dc )
plot(getData("/in") getData("/out") )
modelFile(
    '("/afs/ir.stanford.edu/class/ee315/models/ee315.mod" "")
)
analysis('dc ?print "yes"  )
run()
modelFile(
    '("/afs/ir.stanford.edu/class/ee315/models/ee315.mod" "")
)
saveOption( 'currents "all" )
saveOption( 'save "all" )
save( 'i "/M2/S" "/M2/G" "/M2/B" "/M2/D" "/M0/D" "/M0/S" "/M0/G" )
run()
modelFile(
    '("/afs/ir.stanford.edu/class/ee315/models/ee315.mod" "")
)
run()
modelFile(
    '("/afs/ir.stanford.edu/class/ee315/models/ee315.mod" "")
    '("/afs/.ir.stanford.edu/users/l/e/lenius/ee315/cadence/opus/hw3_save_op.scs" "")
)
run()
modelFile(
    '("/afs/ir.stanford.edu/class/ee315/models/ee315.mod" "")
    '("/afs/.ir.stanford.edu/users/l/e/lenius/ee315/cadence/opus/hw3_save_op.scs" "")
)
save( 'i /M2/S /M2/G /M2/B /M2/D /M0/D /M0/S /M0/G )
run()
modelFile(
    '("/afs/ir.stanford.edu/class/ee315/models/ee315.mod" "")
    '("/afs/.ir.stanford.edu/users/l/e/lenius/ee315/cadence/opus/hw3_save_op.scs" "")
)
run()
modelFile(
    '("/afs/ir.stanford.edu/class/ee315/models/ee315.mod" "")
    '("/afs/.ir.stanford.edu/users/l/e/lenius/ee315/cadence/opus/hw3_save_op.scs" "")
)
run()
modelFile(
    '("/afs/ir.stanford.edu/class/ee315/models/ee315.mod" "")
    '("/afs/.ir.stanford.edu/users/l/e/lenius/ee315/cadence/opus/hw3_save_op.scs" "")
)
run()
modelFile(
    '("/afs/ir.stanford.edu/class/ee315/models/ee315.mod" "")
    '("/afs/.ir.stanford.edu/users/l/e/lenius/ee315/cadence/opus/hw3_save_op.scs" "")
)
run()
